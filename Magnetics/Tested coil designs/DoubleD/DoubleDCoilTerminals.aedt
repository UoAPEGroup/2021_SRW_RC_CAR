# Ansys Electronics Desktop project, version 2021.1
materials:
  aluminum: permeability=1.000021 conductivity=38000000
  copper: permeability=0.999991 conductivity=58000000
  ferrite: permittivity=12 permeability=1000 conductivity=0.01
  vacuum: permittivity=1

design DoubleDCoilWithFerriteBars (Maxwell 3D, EddyCurrent, model units mm)
variables:
  FerriteCoilGap = 3mm  # Z gap between the Primary Ferrite and coils
  SCLength = 81.5mm  # Y length of the secondary coil
  SecondaryFerriteWidth = 15mm  # X width of the secondary Ferrite
  SecondaryFerriteHeight = 8mm  # Z height of the Secondary Ferrite
  SecondaryFerrriteOffset = 25mm  # Z offset of the secondary coil and ferrite
  N2 = 10  # Turns on the secondary coil
  I2 = 1*sqrt(2) A  # Current through the secondary coil
  secondaryYOffset = 50mm  # Y offset of the secondary coil and ferrite
  SecondaryFerriteLength = 108mm  # Y length of the secondary Ferrite
  PrimaryCuttoutOffset = 128.5mm  # Y offset of the hole in the Primary coil. This is mirrored on either side
  PrimaryCuttoutWidth = 94.2mm  # Y Width of the holes in the Primary coil
  I = 1*sqrt(2) A  # Current through the Primary Coil
  SecondaryCoilThickness = 4.3mm  # Thickness of the secondary coil, It is bigger by this dimension on each side in the X and Z axis
  PrimaryCoilWidth = 4.3mm
  AluminumThickness = 5mm
  AluminumFerriteGap = 5mm
  FirstFerritePosition = -450mm
  SecondaryXOffset = 75mm
geometry:
  Region [vacuum] = region(absolute_offset=300mm on all sides)
  SeconadaryCoil [copper] = box(corner=(-(SecondaryFerriteWidth + SecondaryCoilThickness*2)/2 +SecondaryXOffset, -SCLength/2 + secondaryYOffset, SecondaryFerrriteOffset - SecondaryCoilThickness), size=(SecondaryFerriteWidth + 2*SecondaryCoilThickness, SCLength, SecondaryFerriteHeight + 2*SecondaryCoilThickness))
  SecondaryFerrite [ferrite] = box(corner=(-SecondaryFerriteWidth/2 +SecondaryXOffset, -SecondaryFerriteLength/2 + secondaryYOffset, SecondaryFerrriteOffset), size=(SecondaryFerriteWidth, SecondaryFerriteLength, SecondaryFerriteHeight))
  Box4 = box(corner=(-SecondaryFerriteWidth/2 + SecondaryXOffset, -SCLength/2 + secondaryYOffset, SecondaryFerrriteOffset), size=(SecondaryFerriteWidth, SCLength, SecondaryFerriteHeight))
  SeconadaryCoil.subtract(Box4)
  coordinate_system RelativeCS1 = origin=(SecondaryXOffset, 0mm, SecondaryFerrriteOffset) x=(1mm, 0mm, 0mm) y=(0mm, 1mm, 0mm)
  SeconadaryCoil_Section1 [copper] = SeconadaryCoil.section(plane=YZ) in RelativeCS1
  SeconadaryCoil_Section1.separate_bodies()
  PrimaryCoil = box(corner=(-500mm, -150mm, 0mm), size=(1000mm, 150mm, PrimaryCoilWidth))
  Box6 = box(corner=(-477.5mm, -PrimaryCuttoutOffset, 0mm), size=(957mm, PrimaryCuttoutWidth, PrimaryCoilWidth))
  PrimaryCoil.subtract(Box6)
  PrimaryCoil_1 [copper] = PrimaryCoil.duplicate_mirror(point=(0mm, 0mm, 0mm), normal=(0mm, 1mm, 0mm))
  PrimaryCoil_1.unite(PrimaryCoil)
  PrimaryCoil_1.split(plane=XY, keep=PositiveOnly)
  PrimaryCoil_2 [copper] = PrimaryCoil_1.split(plane=ZX, keep=Both)
  PrimaryCoil_1.separate_bodies()
  PrimaryCoil_1_Section1 = PrimaryCoil_1.section(plane=YZ)
  PrimaryCoil_1_Section1_1 [copper] = PrimaryCoil_1_Section1.separate_bodies()
  PrimaryCoil_1_Section1.delete()
  PrimaryCoil_2_Section1 = PrimaryCoil_2.section(plane=YZ)
  PrimaryCoil_2_Section1_1 [copper] = PrimaryCoil_2_Section1.separate_bodies()
  PrimaryCoil_2_Section1.delete()
  Aluminum [aluminum] = box(corner=(-500mm, -150mm, -(FerriteCoilGap + 8mm + AluminumFerriteGap + AluminumThickness)), size=(1000mm, 300mm, AluminumThickness))
  PrimaryFerrite1 [ferrite] = box(corner=(FirstFerritePosition, -108.4mm, -(8mm + FerriteCoilGap)), size=(14.8mm, 216.8mm, 8mm))
  PrimaryFerrite1_1..PrimaryFerrite1_9 [ferrite] = PrimaryFerrite1.duplicate_along_line(step=(95mm, 0mm, 0mm), total=10)
boundaries and excitations:
  Insulating1: Insulating Objects=[PrimaryCoil_1, PrimaryCoil_2]
  LptTerminal1: Coil Terminal Objects=PrimaryCoil_1_Section1_1 Conductor_number=3 Winding=Lpt1 Point_out_of_terminal=false
  LptTerminal2: Coil Terminal Objects=PrimaryCoil_2_Section1_1 Conductor_number=3 Winding=Lpt2 Point_out_of_terminal=false
  LstTerminal: Coil Terminal Objects=SeconadaryCoil_Section1 Conductor_number=N2 Winding=Lst Point_out_of_terminal=false
  Lpt1: Winding Group Type=Current IsSolid=false Current=I ParallelBranchesNum=1 Phase=0deg
  Lpt2: Winding Group Type=Current IsSolid=false Current=I ParallelBranchesNum=1 Phase=0deg
  Lst: Winding Group Type=Current IsSolid=false Current=I2 ParallelBranchesNum=1 Phase=0deg
parameters:
  Matrix1: Matrix Reduce_Matrices{ReduceMatrix1{JoinSeries1{Type="Join in Series" Matrix=6 Sources=Lpt1, Lpt2}}}; Lpt1, Lpt2, Lst:
mesh:
  initial mesh: GlobalCurvilinear{Apply}
setups:
  Setup1: EddyCurrent MaximumPasses=30 MinimumPasses=2 MinimumConvergedPasses=1 PercentRefinement=30 PercentError=1 ExpressionCache{CacheItem{Title=K1 Expression=K TraceID=915 ReportType=2}} ConstantDelta=0s NonLinearResidual=0.0001 Frequency=10kHz
optimetrics:
  HorizontalOffsetSweep: Parametric Sim._Setups=[Setup1]
    sweep secondaryYOffset: LIN 0mm 50mm 25mm
    calculate Lst on Setup1 : LastAdaptive at Freq 10kHz
    calculate Lpt on Setup1 : LastAdaptive at Freq 10kHz
    calculate K on Setup1 : LastAdaptive at Freq 10kHz
  BothOffsets: Parametric Sim._Setups=[Setup1]
    sweep secondaryYOffset: LIN 0mm 50mm 50mm
    sweep SecondaryXOffset: LIN 32mm 75mm 43mm
    calculate Lst on Setup1 : LastAdaptive at Freq 10kHz
    calculate Lpt on Setup1 : LastAdaptive at Freq 10kHz
    calculate M on Setup1 : LastAdaptive at Freq 10kHz
    calculate K on Setup1 : LastAdaptive at Freq 10kHz
    calculate Isc on Setup1 : LastAdaptive at Freq 10kHz
    calculate Voc on Setup1 : LastAdaptive at Freq 10kHz
  SecondaryTurnsAndOffset: Parametric Sim._Setups=[Setup1]
    sweep SecondaryFerrriteOffset: LIN 14mm 20mm 2mm
    sweep N2: LIN 7 16 3
    calculate Lst on Setup1 : LastAdaptive at Freq 10kHz
    calculate Lpt on Setup1 : LastAdaptive at Freq 10kHz
    calculate M on Setup1 : LastAdaptive at Freq 10kHz
    calculate K on Setup1 : LastAdaptive at Freq 10kHz
    calculate Isc on Setup1 : LastAdaptive at Freq 10kHz
    calculate Voc on Setup1 : LastAdaptive at Freq 10kHz
output variables:
  Lst = L(Lst,Lst)
  Lpt = L(JoinSeries1,JoinSeries1)
  M = L(Lst,JoinSeries1)
  K = M/(sqrt(Lst*Lpt))
  Isc = (7.5*sqrt(2)*M)/Lst
  Voc = 6.2831*10000*7.5*sqrt(2)*M
reports:
  Output Variables Plot 1: Lst, Lpt vs secondaryYOffset on Setup1 : LastAdaptive [Freq=all N2=all]
  Output Variables Plot 2: K vs secondaryYOffset on Setup1 : LastAdaptive [Freq=all N2=all]
  Output Variables Plot 3: Isc vs N2 on Setup1 : LastAdaptive [Freq=all SecondaryFerrriteOffset=all secondaryYOffset=all SecondaryXOffset=all]
  Output Variables Plot 4: Voc vs N2 on Setup1 : LastAdaptive [Freq=all SecondaryFerrriteOffset=all secondaryYOffset=all SecondaryXOffset=all]

design DoubleDCoilWith19FerriteBars (Maxwell 3D, EddyCurrent, model units mm)
variables:
  FerriteCoilGap = 2.5mm  # Z gap between the Primary Ferrite and coils
  SCLength = 81.5mm  # Y length of the secondary coil
  SecondaryFerriteWidth = 15mm  # X width of the secondary Ferrite
  SecondaryFerriteHeight = 8mm  # Z height of the Secondary Ferrite
  SecondaryFerrriteOffset = 14mm  # Z offset of the secondary coil and ferrite
  N2 = 10  # Turns on the secondary coil
  I2 = 1*sqrt(2) A  # Current through the secondary coil
  secondaryYOffset = 50mm  # Y offset of the secondary coil and ferrite
  SecondaryFerriteLength = 108mm  # Y length of the secondary Ferrite
  PrimaryCuttoutOffset = 128.5mm  # Y offset of the hole in the Primary coil. This is mirrored on either side
  PrimaryCuttoutWidth = 94.2mm  # Y Width of the holes in the Primary coil
  I = 7.5*sqrt(2) A  # Current through the Primary Coil
  SecondaryCoilThickness = 4.3mm  # Thickness of the secondary coil, It is bigger by this dimension on each side in the X and Z axis
  PrimaryCoilWidth = 4.3mm
  AluminumThickness = 5mm
  AluminumFerriteGap = 6mm
  FirstFerritePosition = -450mm
  SecondaryXOffset = 50mm
geometry:
  Region [vacuum] = region(absolute_offset=300mm on all sides)
  SeconadaryCoil [copper] = box(corner=(-(SecondaryFerriteWidth + SecondaryCoilThickness*2)/2 +SecondaryXOffset, -SCLength/2 + secondaryYOffset, SecondaryFerrriteOffset - SecondaryCoilThickness), size=(SecondaryFerriteWidth + 2*SecondaryCoilThickness, SCLength, SecondaryFerriteHeight + 2*SecondaryCoilThickness))
  SecondaryFerrite [ferrite] = box(corner=(-SecondaryFerriteWidth/2 +SecondaryXOffset, -SecondaryFerriteLength/2 + secondaryYOffset, SecondaryFerrriteOffset), size=(SecondaryFerriteWidth, SecondaryFerriteLength, SecondaryFerriteHeight))
  Box4 = box(corner=(-SecondaryFerriteWidth/2 + SecondaryXOffset, -SCLength/2 + secondaryYOffset, SecondaryFerrriteOffset), size=(SecondaryFerriteWidth, SCLength, SecondaryFerriteHeight))
  SeconadaryCoil.subtract(Box4)
  coordinate_system RelativeCS1 = origin=(SecondaryXOffset, 0mm, SecondaryFerrriteOffset) x=(1mm, 0mm, 0mm) y=(0mm, 1mm, 0mm)
  SeconadaryCoil_Section1 [copper] = SeconadaryCoil.section(plane=YZ) in RelativeCS1
  SeconadaryCoil_Section1.separate_bodies()
  PrimaryCoil = box(corner=(-500mm, -150mm, 0mm), size=(1000mm, 150mm, PrimaryCoilWidth))
  Box6 = box(corner=(-479.5mm, -PrimaryCuttoutOffset, 0mm), size=(957mm, PrimaryCuttoutWidth, PrimaryCoilWidth))
  PrimaryCoil.subtract(Box6)
  PrimaryCoil_1 [copper] = PrimaryCoil.duplicate_mirror(point=(0mm, 0mm, 0mm), normal=(0mm, 1mm, 0mm))
  PrimaryCoil_1.unite(PrimaryCoil)
  PrimaryCoil_1.split(plane=XY, keep=PositiveOnly)
  PrimaryCoil_2 [copper] = PrimaryCoil_1.split(plane=ZX, keep=Both)
  PrimaryCoil_1.separate_bodies()
  PrimaryCoil_1_Section1 = PrimaryCoil_1.section(plane=YZ)
  PrimaryCoil_1_Section1_1 [copper] = PrimaryCoil_1_Section1.separate_bodies()
  PrimaryCoil_1_Section1.delete()
  PrimaryCoil_2_Section1 = PrimaryCoil_2.section(plane=YZ)
  PrimaryCoil_2_Section1_1 [copper] = PrimaryCoil_2_Section1.separate_bodies()
  PrimaryCoil_2_Section1.delete()
  Aluminum [aluminum] = box(corner=(-500mm, -150mm, -(FerriteCoilGap + 8mm + AluminumFerriteGap + AluminumThickness)), size=(1000mm, 300mm, AluminumThickness))
  PrimaryFerrite1 [ferrite] = box(corner=(FirstFerritePosition, -108.4mm, -(8mm + FerriteCoilGap)), size=(14.8mm, 216.8mm, 8mm))
  PrimaryFerrite1_1..PrimaryFerrite1_8 [ferrite] = PrimaryFerrite1.duplicate_along_line(step=(110mm, 0mm, 0mm), total=9) in RelativeCS1
boundaries and excitations:
  Insulating1: Insulating Objects=[PrimaryCoil_1, PrimaryCoil_2]
  LptTerminal1: Coil Terminal Objects=PrimaryCoil_1_Section1_1 Conductor_number=3 Winding=Lpt1 Point_out_of_terminal=false
  LptTerminal2: Coil Terminal Objects=PrimaryCoil_2_Section1_1 Conductor_number=3 Winding=Lpt2 Point_out_of_terminal=false
  LstTerminal: Coil Terminal Objects=SeconadaryCoil_Section1 Conductor_number=N2 Winding=Lst Point_out_of_terminal=false
  Lpt1: Winding Group Type=Current IsSolid=false Current=I ParallelBranchesNum=1 Phase=0deg
  Lpt2: Winding Group Type=Current IsSolid=false Current=I ParallelBranchesNum=1 Phase=0deg
  Lst: Winding Group Type=Current IsSolid=false Current=I2 ParallelBranchesNum=1 Phase=0deg
parameters:
  Matrix1: Matrix Reduce_Matrices{ReduceMatrix1{JoinSeries1{Type="Join in Series" Matrix=6 Sources=Lpt1, Lpt2}}}; Lpt1, Lpt2, Lst:
mesh:
  initial mesh: GlobalCurvilinear{Apply}
setups:
  Setup1: EddyCurrent MaximumPasses=30 MinimumPasses=2 MinimumConvergedPasses=1 PercentRefinement=30 PercentError=1 ExpressionCache{CacheItem{Title=K1 Expression=K TraceID=915 ReportType=2}} ConstantDelta=0s NonLinearResidual=0.0001 Frequency=10kHz
optimetrics:
  HorizontalOffsetSweep: Parametric Sim._Setups=[Setup1]
    sweep secondaryYOffset: LIN 0mm 50mm 25mm
    calculate Lst on Setup1 : LastAdaptive at Freq 10kHz
    calculate Lpt on Setup1 : LastAdaptive at Freq 10kHz
    calculate K on Setup1 : LastAdaptive at Freq 10kHz
  AluminumFerriteGap: Parametric Sim._Setups=[Setup1]
    sweep AluminumFerriteGap: LIN 2mm 10mm 1mm
    calculate K on Setup1 : LastAdaptive at Freq 10kHz
  BothOffsets: Parametric Sim._Setups=[Setup1]
    sweep secondaryYOffset: LIN 0mm 50mm 50mm
    sweep SecondaryXOffset: LIN 0mm 50mm 25mm
    calculate Lst on Setup1 : LastAdaptive at Freq 10kHz
    calculate M on Setup1 : LastAdaptive at Freq 10kHz
    calculate Lpt on Setup1 : LastAdaptive at Freq 10kHz
    calculate K on Setup1 : LastAdaptive at Freq 10kHz
    calculate Isc on Setup1 : LastAdaptive at Freq 10kHz
  SecondaryTurnsSweep: Parametric Sim._Setups=[Setup1]
    sweep N2: LIN 15 17 1
    calculate Lst on Setup1 : LastAdaptive at Freq 10kHz
    calculate M on Setup1 : LastAdaptive at Freq 10kHz
    calculate K on Setup1 : LastAdaptive at Freq 10kHz
    calculate Isc on Setup1 : LastAdaptive at Freq 10kHz
    calculate Voc on Setup1 : LastAdaptive at Freq 10kHz
  SecondaryCoilHeight: Parametric Sim._Setups=[Setup1]
    sweep SecondaryFerrriteOffset: LIN 10mm 16mm 2mm
    calculate Lst on Setup1 : LastAdaptive at Freq 10kHz
    calculate Lpt on Setup1 : LastAdaptive at Freq 10kHz
    calculate M on Setup1 : LastAdaptive at Freq 10kHz
    calculate K on Setup1 : LastAdaptive at Freq 10kHz
    calculate Isc on Setup1 : LastAdaptive at Freq 10kHz
    calculate Voc on Setup1 : LastAdaptive at Freq 10kHz
  secondaryYOffset: Parametric Sim._Setups=[Setup1]
    sweep secondaryYOffset: LIN 25mm 75mm 25mm
    calculate Voc on Setup1 : LastAdaptive at Freq 10kHz
    calculate Isc on Setup1 : LastAdaptive at Freq 10kHz
    calculate K on Setup1 : LastAdaptive at Freq 10kHz
output variables:
  Lst = L(Lst,Lst)
  Lpt = L(JoinSeries1,JoinSeries1)
  M = L(Lst,JoinSeries1)
  K = M/(sqrt(Lst*Lpt))
  Isc = (M*7.5*sqrt(2))/Lst
  Voc = 6.2831*10000*7.5*sqrt(2)*M
reports:
  Output Variables Plot 1: Lst, Lpt vs secondaryYOffset on Setup1 : LastAdaptive [Freq=all]
  Output Variables Plot 2: K vs secondaryYOffset on Setup1 : LastAdaptive [Freq=all]

design DoubleDCoilWith17FerriteBars (Maxwell 3D, EddyCurrent, model units mm)
variables:
  FerriteCoilGap = 3mm  # Z gap between the Primary Ferrite and coils
  SCLength = 81.5mm  # Y length of the secondary coil
  SecondaryFerriteWidth = 15mm  # X width of the secondary Ferrite
  SecondaryFerriteHeight = 8mm  # Z height of the Secondary Ferrite
  SecondaryFerrriteOffset = 25mm  # Z offset of the secondary coil and ferrite
  N2 = 10  # Turns on the secondary coil
  I2 = 1*sqrt(2) A  # Current through the secondary coil
  secondaryYOffset = 0mm  # Y offset of the secondary coil and ferrite
  SecondaryFerriteLength = 108mm  # Y length of the secondary Ferrite
  PrimaryCuttoutOffset = 128.5mm  # Y offset of the hole in the Primary coil. This is mirrored on either side
  PrimaryCuttoutWidth = 94.2mm  # Y Width of the holes in the Primary coil
  I = 1*sqrt(2) A  # Current through the Primary Coil
  SecondaryCoilThickness = 4.3mm  # Thickness of the secondary coil, It is bigger by this dimension on each side in the X and Z axis
  PrimaryCoilWidth = 4.3mm
  AluminumThickness = 5mm
  AluminumFerriteGap = 5mm
  FirstFerritePosition = -450mm
  SecondaryXOffset = 32mm
geometry:
  Region [vacuum] = region(absolute_offset=300mm on all sides)
  SeconadaryCoil [copper] = box(corner=(-(SecondaryFerriteWidth + SecondaryCoilThickness*2)/2 +SecondaryXOffset, -SCLength/2 + secondaryYOffset, SecondaryFerrriteOffset - SecondaryCoilThickness), size=(SecondaryFerriteWidth + 2*SecondaryCoilThickness, SCLength, SecondaryFerriteHeight + 2*SecondaryCoilThickness))
  SecondaryFerrite [ferrite] = box(corner=(-SecondaryFerriteWidth/2 +SecondaryXOffset, -SecondaryFerriteLength/2 + secondaryYOffset, SecondaryFerrriteOffset), size=(SecondaryFerriteWidth, SecondaryFerriteLength, SecondaryFerriteHeight))
  Box4 = box(corner=(-SecondaryFerriteWidth/2 + SecondaryXOffset, -SCLength/2 + secondaryYOffset, SecondaryFerrriteOffset), size=(SecondaryFerriteWidth, SCLength, SecondaryFerriteHeight))
  SeconadaryCoil.subtract(Box4)
  coordinate_system RelativeCS1 = origin=(SecondaryXOffset, 0mm, SecondaryFerrriteOffset) x=(1mm, 0mm, 0mm) y=(0mm, 1mm, 0mm)
  SeconadaryCoil_Section1 [copper] = SeconadaryCoil.section(plane=YZ) in RelativeCS1
  SeconadaryCoil_Section1.separate_bodies()
  PrimaryCoil = box(corner=(-500mm, -150mm, 0mm), size=(1000mm, 150mm, PrimaryCoilWidth))
  Box6 = box(corner=(-450mm, -PrimaryCuttoutOffset, 0mm), size=(900mm, PrimaryCuttoutWidth, PrimaryCoilWidth))
  PrimaryCoil.subtract(Box6)
  PrimaryCoil_1 [copper] = PrimaryCoil.duplicate_mirror(point=(0mm, 0mm, 0mm), normal=(0mm, 1mm, 0mm))
  PrimaryCoil_1.unite(PrimaryCoil)
  PrimaryCoil_1.split(plane=XY, keep=PositiveOnly)
  PrimaryCoil_2 [copper] = PrimaryCoil_1.split(plane=ZX, keep=Both)
  PrimaryCoil_1.separate_bodies()
  PrimaryCoil_1_Section1 = PrimaryCoil_1.section(plane=YZ)
  PrimaryCoil_1_Section1_1 [copper] = PrimaryCoil_1_Section1.separate_bodies()
  PrimaryCoil_1_Section1.delete()
  PrimaryCoil_2_Section1 = PrimaryCoil_2.section(plane=YZ)
  PrimaryCoil_2_Section1_1 [copper] = PrimaryCoil_2_Section1.separate_bodies()
  PrimaryCoil_2_Section1.delete()
  Aluminum [aluminum] = box(corner=(-500mm, -150mm, -(FerriteCoilGap + 8mm + AluminumFerriteGap + AluminumThickness)), size=(1000mm, 300mm, AluminumThickness))
  PrimaryFerrite1 [ferrite] = box(corner=(FirstFerritePosition, -108.4mm, -(8mm + FerriteCoilGap)), size=(14.8mm, 216.8mm, 8mm))
  PrimaryFerrite1_1..PrimaryFerrite1_7 [ferrite] = PrimaryFerrite1.duplicate_along_line(step=(120mm, 0mm, 0mm), total=8) in RelativeCS1
boundaries and excitations:
  Insulating1: Insulating Objects=[PrimaryCoil_1, PrimaryCoil_2]
  LptTerminal1: Coil Terminal Objects=PrimaryCoil_1_Section1_1 Conductor_number=3 Winding=Lpt1 Point_out_of_terminal=false
  LptTerminal2: Coil Terminal Objects=PrimaryCoil_2_Section1_1 Conductor_number=3 Winding=Lpt2 Point_out_of_terminal=false
  LstTerminal: Coil Terminal Objects=SeconadaryCoil_Section1 Conductor_number=N2 Winding=Lst Point_out_of_terminal=false
  Lpt1: Winding Group Type=Current IsSolid=false Current=I ParallelBranchesNum=1 Phase=0deg
  Lpt2: Winding Group Type=Current IsSolid=false Current=I ParallelBranchesNum=1 Phase=0deg
  Lst: Winding Group Type=Current IsSolid=false Current=I2 ParallelBranchesNum=1 Phase=0deg
parameters:
  Matrix1: Matrix Reduce_Matrices{ReduceMatrix1{JoinSeries1{Type="Join in Series" Matrix=6 Sources=Lpt1, Lpt2}}}; Lpt1, Lpt2, Lst:
mesh:
  initial mesh: GlobalCurvilinear{Apply}
setups:
  Setup1: EddyCurrent MaximumPasses=30 MinimumPasses=2 MinimumConvergedPasses=1 PercentRefinement=30 PercentError=1 ExpressionCache{CacheItem{Title=K1 Expression=K TraceID=915 ReportType=2}} ConstantDelta=0s NonLinearResidual=0.0001 Frequency=10kHz
optimetrics:
  HorizontalOffsetSweep: Parametric Sim._Setups=[Setup1]
    sweep secondaryYOffset: LIN 0mm 50mm 25mm
    calculate Lst on Setup1 : LastAdaptive at Freq 10kHz
    calculate Lpt on Setup1 : LastAdaptive at Freq 10kHz
    calculate K on Setup1 : LastAdaptive at Freq 10kHz
output variables:
  Lst = L(Lst,Lst)
  Lpt = L(JoinSeries1,JoinSeries1)
  M = L(Lst,JoinSeries1)
  K = M/(sqrt(Lst*Lpt))
reports:
  Output Variables Plot 1: Lpt, Lst vs secondaryYOffset on Setup1 : LastAdaptive [Freq=all]
  Output Variables Plot 2: K vs secondaryYOffset on Setup1 : LastAdaptive [Freq=all]

design DoubleDCoilWith15FerriteBars (Maxwell 3D, EddyCurrent, model units mm)
variables:
  FerriteCoilGap = 3mm  # Z gap between the Primary Ferrite and coils
  SCLength = 81.5mm  # Y length of the secondary coil
  SecondaryFerriteWidth = 15mm  # X width of the secondary Ferrite
  SecondaryFerriteHeight = 8mm  # Z height of the Secondary Ferrite
  SecondaryFerrriteOffset = 25mm  # Z offset of the secondary coil and ferrite
  N2 = 10  # Turns on the secondary coil
  I2 = 1*sqrt(2) A  # Current through the secondary coil
  secondaryYOffset = 0mm  # Y offset of the secondary coil and ferrite
  SecondaryFerriteLength = 108mm  # Y length of the secondary Ferrite
  PrimaryCuttoutOffset = 128.5mm  # Y offset of the hole in the Primary coil. This is mirrored on either side
  PrimaryCuttoutWidth = 94.2mm  # Y Width of the holes in the Primary coil
  I = 1*sqrt(2) A  # Current through the Primary Coil
  SecondaryCoilThickness = 4.3mm  # Thickness of the secondary coil, It is bigger by this dimension on each side in the X and Z axis
  PrimaryCoilWidth = 4.3mm
  AluminumThickness = 5mm
  AluminumFerriteGap = 5mm
  FirstFerritePosition = -450mm
  SecondaryXOffset = -20mm
geometry:
  Region [vacuum] = region(absolute_offset=300mm on all sides)
  SeconadaryCoil [copper] = box(corner=(-(SecondaryFerriteWidth + SecondaryCoilThickness*2)/2 +SecondaryXOffset, -SCLength/2 + secondaryYOffset, SecondaryFerrriteOffset - SecondaryCoilThickness), size=(SecondaryFerriteWidth + 2*SecondaryCoilThickness, SCLength, SecondaryFerriteHeight + 2*SecondaryCoilThickness))
  SecondaryFerrite [ferrite] = box(corner=(-SecondaryFerriteWidth/2 +SecondaryXOffset, -SecondaryFerriteLength/2 + secondaryYOffset, SecondaryFerrriteOffset), size=(SecondaryFerriteWidth, SecondaryFerriteLength, SecondaryFerriteHeight))
  Box4 = box(corner=(-SecondaryFerriteWidth/2 + SecondaryXOffset, -SCLength/2 + secondaryYOffset, SecondaryFerrriteOffset), size=(SecondaryFerriteWidth, SCLength, SecondaryFerriteHeight))
  SeconadaryCoil.subtract(Box4)
  coordinate_system RelativeCS1 = origin=(SecondaryXOffset, 0mm, SecondaryFerrriteOffset) x=(1mm, 0mm, 0mm) y=(0mm, 1mm, 0mm)
  SeconadaryCoil_Section1 [copper] = SeconadaryCoil.section(plane=YZ) in RelativeCS1
  SeconadaryCoil_Section1.separate_bodies()
  PrimaryCoil = box(corner=(-500mm, -150mm, 0mm), size=(1000mm, 150mm, PrimaryCoilWidth))
  Box6 = box(corner=(-450mm, -PrimaryCuttoutOffset, 0mm), size=(900mm, PrimaryCuttoutWidth, PrimaryCoilWidth))
  PrimaryCoil.subtract(Box6)
  PrimaryCoil_1 [copper] = PrimaryCoil.duplicate_mirror(point=(0mm, 0mm, 0mm), normal=(0mm, 1mm, 0mm))
  PrimaryCoil_1.unite(PrimaryCoil)
  PrimaryCoil_1.split(plane=XY, keep=PositiveOnly)
  PrimaryCoil_2 [copper] = PrimaryCoil_1.split(plane=ZX, keep=Both)
  PrimaryCoil_1.separate_bodies()
  PrimaryCoil_1_Section1 = PrimaryCoil_1.section(plane=YZ)
  PrimaryCoil_1_Section1_1 [copper] = PrimaryCoil_1_Section1.separate_bodies()
  PrimaryCoil_1_Section1.delete()
  PrimaryCoil_2_Section1 = PrimaryCoil_2.section(plane=YZ)
  PrimaryCoil_2_Section1_1 [copper] = PrimaryCoil_2_Section1.separate_bodies()
  PrimaryCoil_2_Section1.delete()
  Aluminum [aluminum] = box(corner=(-500mm, -150mm, -(FerriteCoilGap + 8mm + AluminumFerriteGap + AluminumThickness)), size=(1000mm, 300mm, AluminumThickness))
  PrimaryFerrite1 [ferrite] = box(corner=(FirstFerritePosition, -108.4mm, -(8mm + FerriteCoilGap)), size=(14.8mm, 216.8mm, 8mm))
  PrimaryFerrite1_1..PrimaryFerrite1_6 [ferrite] = PrimaryFerrite1.duplicate_along_line(step=(140mm, 0mm, 0mm), total=7) in RelativeCS1
boundaries and excitations:
  Insulating1: Insulating Objects=[PrimaryCoil_1, PrimaryCoil_2]
  LptTerminal1: Coil Terminal Objects=PrimaryCoil_1_Section1_1 Conductor_number=3 Winding=Lpt1 Point_out_of_terminal=false
  LptTerminal2: Coil Terminal Objects=PrimaryCoil_2_Section1_1 Conductor_number=3 Winding=Lpt2 Point_out_of_terminal=false
  LstTerminal: Coil Terminal Objects=SeconadaryCoil_Section1 Conductor_number=N2 Winding=Lst Point_out_of_terminal=false
  Lpt1: Winding Group Type=Current IsSolid=false Current=I ParallelBranchesNum=1 Phase=0deg
  Lpt2: Winding Group Type=Current IsSolid=false Current=I ParallelBranchesNum=1 Phase=0deg
  Lst: Winding Group Type=Current IsSolid=false Current=I2 ParallelBranchesNum=1 Phase=0deg
parameters:
  Matrix1: Matrix Reduce_Matrices{ReduceMatrix1{JoinSeries1{Type="Join in Series" Matrix=6 Sources=Lpt1, Lpt2}}}; Lpt1, Lpt2, Lst:
mesh:
  initial mesh: GlobalCurvilinear{Apply}
setups:
  Setup1: EddyCurrent MaximumPasses=30 MinimumPasses=2 MinimumConvergedPasses=1 PercentRefinement=30 PercentError=1 ExpressionCache{CacheItem{Title=K1 Expression=K TraceID=915 ReportType=2}} ConstantDelta=0s NonLinearResidual=0.0001 Frequency=10kHz
optimetrics:
  HorizontalOffsetSweep: Parametric Sim._Setups=[Setup1]
    sweep secondaryYOffset: LIN 0mm 50mm 25mm
    calculate Lst on Setup1 : LastAdaptive at Freq 10kHz
    calculate Lpt on Setup1 : LastAdaptive at Freq 10kHz
    calculate K on Setup1 : LastAdaptive at Freq 10kHz
output variables:
  Lst = L(Lst,Lst)
  Lpt = L(JoinSeries1,JoinSeries1)
  M = L(Lst,JoinSeries1)
  K = M/(sqrt(Lst*Lpt))
reports:
  Output Variables Plot 1: Lpt, Lst vs secondaryYOffset on Setup1 : LastAdaptive [Freq=all]
  Output Variables Plot 2: K vs secondaryYOffset on Setup1 : LastAdaptive [Freq=all]
