# Ansys Electronics Desktop project, version 2021.1
materials:
  copper: permeability=0.999991 conductivity=58000000
  ferrite: permittivity=12 permeability=1000 conductivity=0.01
  vacuum: permittivity=1
  aluminum: permeability=1.000021 conductivity=38000000
  pec: conductivity=1e+30

design DoubleDCoil (Maxwell 3D, Magnetostatic, model units mm)
variables:
  FerriteWidth = 230mm  # Y dimension of the Primary Ferrite
  FerriteCoilGap = 2mm  # Z gap between the Primary Ferrite and coils
  SCLength = 40mm  # Y length of the secondary coil
  SecondaryFerriteWidth = 15mm  # X width of the secondary Ferrite
  SecondaryFerriteHeight = 8mm  # Z height of the Secondary Ferrite
  SecondaryFerrriteOffset = 25mm  # Z offset of the secondary coil and ferrite
  N2 = 10  # Turns on the secondary coil
  I2 = 1*sqrt(2) A  # Current through the secondary coil
  secondaryYOffset = 50mm  # Y offset of the secondary coil and ferrite
  SecondaryFerriteLength = 100mm  # Y length of the secondary Ferrite
  PrimaryCuttoutOffset = 125mm  # Y offset of the hole in the Primary coil. This is mirrored on either side
  PrimaryCuttoutWidth = 75mm  # Y Width of the holes in the Primary coil
  N = 10  # Number of turns in the Primary Coil
  I = 1*sqrt(2) A  # Current through the Primary Coil
  SecondaryCoilThickness = 5mm  # Thickness of the secondary coil, It is bigger by this dimension on each side in the X and Z axis
  PrimaryCoilWidth = 5mm
geometry:
  PrimaryFerrite [ferrite] = box(corner=(-500mm, -FerriteWidth/2, -FerriteCoilGap - 8mm), size=(1000mm, FerriteWidth, 8mm))
  Region [vacuum] = region(absolute_offset=300mm on all sides)
  SeconadaryCoil [copper] = box(corner=(-(SecondaryFerriteWidth + SecondaryCoilThickness*2)/2, -SCLength/2 + secondaryYOffset, SecondaryFerrriteOffset - SecondaryCoilThickness), size=(SecondaryFerriteWidth + 2*SecondaryCoilThickness, SCLength, SecondaryFerriteHeight + 2*SecondaryCoilThickness))
  SecondaryFerrite [ferrite] = box(corner=(-SecondaryFerriteWidth/2, -SecondaryFerriteLength/2 + secondaryYOffset, SecondaryFerrriteOffset), size=(SecondaryFerriteWidth, SecondaryFerriteLength, SecondaryFerriteHeight))
  Box4 = box(corner=(-SecondaryFerriteWidth/2, -SCLength/2 + secondaryYOffset, SecondaryFerrriteOffset), size=(SecondaryFerriteWidth, SCLength, SecondaryFerriteHeight))
  SeconadaryCoil.subtract(Box4)
  SeconadaryCoil_Section1 [copper] = SeconadaryCoil.section(plane=YZ)
  SeconadaryCoil_Section1.separate_bodies()
  PrimaryCoil = box(corner=(-500mm, -150mm, 0mm), size=(1000mm, 150mm, PrimaryCoilWidth))
  Box6 = box(corner=(-450mm, -PrimaryCuttoutOffset, 0mm), size=(900mm, PrimaryCuttoutWidth, PrimaryCoilWidth))
  PrimaryCoil.subtract(Box6)
  PrimaryCoil_1 [copper] = PrimaryCoil.duplicate_mirror(point=(0mm, 0mm, 0mm), normal=(0mm, 1mm, 0mm))
  PrimaryCoil_1.unite(PrimaryCoil)
  PrimaryCoil_1.split(plane=XY, keep=PositiveOnly)
  PrimaryCoil_2 [copper] = PrimaryCoil_1.split(plane=ZX, keep=Both)
  PrimaryCoil_1.separate_bodies()
  PrimaryCoil_1_Section1 = PrimaryCoil_1.section(plane=YZ)
  PrimaryCoil_1_Section1_1 [copper] = PrimaryCoil_1_Section1.separate_bodies()
  PrimaryCoil_1_Section1.delete()
  PrimaryCoil_2_Section1 = PrimaryCoil_2.section(plane=YZ)
  PrimaryCoil_2_Section1_1 [copper] = PrimaryCoil_2_Section1.separate_bodies()
  PrimaryCoil_2_Section1.delete()
boundaries and excitations:
  Insulating1: Insulating Objects=[PrimaryCoil_1, PrimaryCoil_2]
  L_st: Current Objects=SeconadaryCoil_Section1 Current=N2*I2 IsSolid=false Point_out_of_terminal=false
  L_pt1: Current Objects=PrimaryCoil_1_Section1_1 Current=N*I IsSolid=false Point_out_of_terminal=false
  L_pt2: Current Objects=PrimaryCoil_2_Section1_1 Current=N*I IsSolid=false Point_out_of_terminal=false
parameters:
  Matrix1: Matrix L_st: NumberOfTurns=N2; L_pt1, L_pt2: NumberOfTurns=1; group Group1 = L_pt1, L_pt2 (1 parallel)
mesh:
  initial mesh: GlobalCurvilinear{Apply}
setups:
  Setup1: Magnetostatic MaximumPasses=30 MinimumPasses=2 MinimumConvergedPasses=1 PercentRefinement=30 PercentError=1 NonLinearResidual=0.001
optimetrics:
  CuttoutWidthSweep: Parametric Sim._Setups=[Setup1]
    sweep PrimaryCuttoutWidth: LIN 50mm 125mm 12.5mm
    calculate L_st_sim on Setup1 : LastAdaptive
    calculate k on Setup1 : LastAdaptive
    calculate L_pt_sim on Setup1 : LastAdaptive
    calculate M on Setup1 : LastAdaptive
  CuttoutOffsetSweep: Parametric Sim._Setups=[Setup1]
    sweep PrimaryCuttoutOffset: LIN 80mm 140mm 10mm
    calculate L_pt_sim on Setup1 : LastAdaptive
    calculate L_st_sim on Setup1 : LastAdaptive
    calculate k on Setup1 : LastAdaptive
    calculate M on Setup1 : LastAdaptive
  PrimaryHeightSweep: Parametric Sim._Setups=[Setup1]
    sweep PrimaryCoilWidth: LIN 2.5mm 10.5mm 0.5mm
    calculate L_st_sim on Setup1 : LastAdaptive
    calculate Matrix1.L(Group1,Group1) on Setup1 : LastAdaptive
  FerriteWidthSweep: Parametric Sim._Setups=[Setup1]
    sweep FerriteWidth: LIN 80mm 300mm 20mm
    calculate L_pt_sim on Setup1 : LastAdaptive
    calculate L_st_sim on Setup1 : LastAdaptive
    calculate k on Setup1 : LastAdaptive
    calculate Matrix1.CplCoef(L_pt1,L_pt2) on Setup1 : LastAdaptive
    calculate Matrix1.CplCoef(L_pt1,L_st) on Setup1 : LastAdaptive
    calculate Matrix1.CplCoef(L_pt2,L_st) on Setup1 : LastAdaptive
  SecondaryOffsetSweep: Parametric Sim._Setups=[Setup1]
    sweep secondaryYOffset: LIN 0mm 50mm 10mm
    calculate k on Setup1 : LastAdaptive
    calculate L_st_sim on Setup1 : LastAdaptive
    calculate L_pt_sim on Setup1 : LastAdaptive
output variables:
  L_pt_sim = Matrix1.L(Group1,Group1)
  L_st_sim = Matrix1.L(L_st,L_st)
  M = k*sqrt(L_pt_sim*L_st_sim)
  k = Matrix1.CplCoef(L_pt1,L_st)+Matrix1.CplCoef(L_pt2,L_st)
reports:
  L Plot 1: Matrix1.L(Group1,Group1) vs PrimaryCoilWidth on Setup1 : LastAdaptive [PrimaryCuttoutOffset=all PrimaryCuttoutWidth=all]

design DoubleDCoilWithAluminum (Maxwell 3D, EddyCurrent, model units mm)
variables:
  FerriteWidth = 230mm  # Y dimension of the Primary Ferrite
  FerriteCoilGap = 10mm  # Z gap between the Primary Ferrite and coils
  SCLength = 40mm  # Y length of the secondary coil
  SecondaryFerriteWidth = 15mm  # X width of the secondary Ferrite
  SecondaryFerriteHeight = 8mm  # Z height of the Secondary Ferrite
  SecondaryFerrriteOffset = 30mm  # Z offset of the secondary coil and ferrite
  N2 = 10  # Turns on the secondary coil
  I2 = 1*sqrt(2) A  # Current through the secondary coil
  secondaryYOffset = 0mm  # Y offset of the secondary coil and ferrite
  SecondaryFerriteLength = 100mm  # Y length of the secondary Ferrite
  PrimaryCuttoutOffset = 125mm  # Y offset of the hole in the Primary coil. This is mirrored on either side
  PrimaryCuttoutWidth = 75mm  # Y Width of the holes in the Primary coil
  N = 10  # Number of turns in the Primary Coil
  I = 1*sqrt(2) A  # Current through the Primary Coil
  SecondaryCoilThickness = 5mm  # Thickness of the secondary coil, It is bigger by this dimension on each side in the X and Z axis
  PrimaryCoilWidth = 5mm
  AluminumThickness = 5mm
  AluminumFerriteGap = 5mm
geometry:
  PrimaryFerrite [ferrite] = box(corner=(-500mm, -FerriteWidth/2, -FerriteCoilGap - 8mm), size=(1000mm, FerriteWidth, 8mm))
  Region [vacuum] = region(absolute_offset=300mm on all sides)
  SeconadaryCoil [copper] = box(corner=(-(SecondaryFerriteWidth + SecondaryCoilThickness*2)/2, -SCLength/2 + secondaryYOffset, SecondaryFerrriteOffset - SecondaryCoilThickness), size=(SecondaryFerriteWidth + 2*SecondaryCoilThickness, SCLength, SecondaryFerriteHeight + 2*SecondaryCoilThickness))
  SecondaryFerrite [ferrite] = box(corner=(-SecondaryFerriteWidth/2, -SecondaryFerriteLength/2 + secondaryYOffset, SecondaryFerrriteOffset), size=(SecondaryFerriteWidth, SecondaryFerriteLength, SecondaryFerriteHeight))
  Box4 = box(corner=(-SecondaryFerriteWidth/2, -SCLength/2 + secondaryYOffset, SecondaryFerrriteOffset), size=(SecondaryFerriteWidth, SCLength, SecondaryFerriteHeight))
  SeconadaryCoil.subtract(Box4)
  SeconadaryCoil_Section1 [copper] = SeconadaryCoil.section(plane=YZ)
  SeconadaryCoil_Section1.separate_bodies()
  PrimaryCoil = box(corner=(-500mm, -150mm, 0mm), size=(1000mm, 150mm, PrimaryCoilWidth))
  Box6 = box(corner=(-450mm, -PrimaryCuttoutOffset, 0mm), size=(900mm, PrimaryCuttoutWidth, PrimaryCoilWidth))
  PrimaryCoil.subtract(Box6)
  PrimaryCoil_1 [copper] = PrimaryCoil.duplicate_mirror(point=(0mm, 0mm, 0mm), normal=(0mm, 1mm, 0mm))
  PrimaryCoil_1.unite(PrimaryCoil)
  PrimaryCoil_1.split(plane=XY, keep=PositiveOnly)
  PrimaryCoil_2 [copper] = PrimaryCoil_1.split(plane=ZX, keep=Both)
  PrimaryCoil_1.separate_bodies()
  PrimaryCoil_1_Section1 = PrimaryCoil_1.section(plane=YZ)
  PrimaryCoil_1_Section1_1 [copper] = PrimaryCoil_1_Section1.separate_bodies()
  PrimaryCoil_1_Section1.delete()
  PrimaryCoil_2_Section1 = PrimaryCoil_2.section(plane=YZ)
  PrimaryCoil_2_Section1_1 [copper] = PrimaryCoil_2_Section1.separate_bodies()
  PrimaryCoil_2_Section1.delete()
  Aluminum [aluminum] = box(corner=(-500mm, -150mm, -(FerriteCoilGap + 8mm + AluminumFerriteGap + AluminumThickness)), size=(1000mm, 300mm, AluminumThickness))
boundaries and excitations:
  Insulating1: Insulating Objects=[PrimaryCoil_1, PrimaryCoil_2]
  L_st: Current Objects=SeconadaryCoil_Section1 Phase=0deg Current=N2*I2 IsSolid=false Point_out_of_terminal=false
  L_pt1: Current Objects=PrimaryCoil_1_Section1_1 Phase=0deg Current=N*I IsSolid=false Point_out_of_terminal=false
  L_pt2: Current Objects=PrimaryCoil_2_Section1_1 Phase=0deg Current=N*I IsSolid=false Point_out_of_terminal=false
parameters:
  Matrix1: Matrix L_st, L_pt1, L_pt2:
mesh:
  initial mesh: GlobalCurvilinear{Apply}
setups:
  Setup1: EddyCurrent MaximumPasses=30 MinimumPasses=2 MinimumConvergedPasses=1 PercentRefinement=30 PercentError=1 NonLinearResidual=0.0001 Frequency=60Hz
optimetrics:
  ParametricSetup1: Parametric Sim._Setups=[Setup1]
    sweep secondaryYOffset: LIN 0mm 50mm 10mm
    calculate L_st_sim on Setup1 : LastAdaptive at Freq 60Hz
    calculate k on Setup1 : LastAdaptive at Freq 60Hz
output variables:
  L_pt_sim = Matrix1.L(Group1,Group1)
  L_st_sim = Matrix1.L(L_st,L_st)
  M = k*sqrt(L_pt_sim*L_st_sim)
  k = Matrix1.CplCoef(L_pt1,L_st)+Matrix1.CplCoef(L_pt2,L_st)

design DoubleDCoilWithFerriteBars (Maxwell 3D, EddyCurrent, model units mm)
variables:
  FerriteCoilGap = 3mm  # Z gap between the Primary Ferrite and coils
  SCLength = 40mm  # Y length of the secondary coil
  SecondaryFerriteWidth = 15mm  # X width of the secondary Ferrite
  SecondaryFerriteHeight = 8mm  # Z height of the Secondary Ferrite
  SecondaryFerrriteOffset = 20mm  # Z offset of the secondary coil and ferrite
  N2 = 10  # Turns on the secondary coil
  I2 = 1*sqrt(2) A  # Current through the secondary coil
  secondaryYOffset = 0mm  # Y offset of the secondary coil and ferrite
  SecondaryFerriteLength = 108mm  # Y length of the secondary Ferrite
  PrimaryCuttoutOffset = 110mm  # Y offset of the hole in the Primary coil. This is mirrored on either side
  PrimaryCuttoutWidth = 75mm  # Y Width of the holes in the Primary coil
  N = 10  # Number of turns in the Primary Coil
  I = 1*sqrt(2) A  # Current through the Primary Coil
  SecondaryCoilThickness = 5mm  # Thickness of the secondary coil, It is bigger by this dimension on each side in the X and Z axis
  PrimaryCoilWidth = 5mm
  AluminumThickness = 5mm
  AluminumFerriteGap = 5mm
  FirstFerritePosition = -450mm
  PrimaryFerriteSpacing = 100mm
geometry:
  Region [vacuum] = region(absolute_offset=300mm on all sides)
  SeconadaryCoil [copper] = box(corner=(-(SecondaryFerriteWidth + SecondaryCoilThickness*2)/2, -SCLength/2 + secondaryYOffset, SecondaryFerrriteOffset - SecondaryCoilThickness), size=(SecondaryFerriteWidth + 2*SecondaryCoilThickness, SCLength, SecondaryFerriteHeight + 2*SecondaryCoilThickness))
  SecondaryFerrite [ferrite] = box(corner=(-SecondaryFerriteWidth/2, -SecondaryFerriteLength/2 + secondaryYOffset, SecondaryFerrriteOffset), size=(SecondaryFerriteWidth, SecondaryFerriteLength, SecondaryFerriteHeight))
  Box4 = box(corner=(-SecondaryFerriteWidth/2, -SCLength/2 + secondaryYOffset, SecondaryFerrriteOffset), size=(SecondaryFerriteWidth, SCLength, SecondaryFerriteHeight))
  SeconadaryCoil.subtract(Box4)
  SeconadaryCoil_Section1 [copper] = SeconadaryCoil.section(plane=YZ)
  SeconadaryCoil_Section1.separate_bodies()
  PrimaryCoil = box(corner=(-500mm, -150mm, 0mm), size=(1000mm, 150mm, PrimaryCoilWidth))
  Box6 = box(corner=(-450mm, -PrimaryCuttoutOffset, 0mm), size=(900mm, PrimaryCuttoutWidth, PrimaryCoilWidth))
  PrimaryCoil.subtract(Box6)
  PrimaryCoil_1 [copper] = PrimaryCoil.duplicate_mirror(point=(0mm, 0mm, 0mm), normal=(0mm, 1mm, 0mm))
  PrimaryCoil_1.unite(PrimaryCoil)
  PrimaryCoil_1.split(plane=XY, keep=PositiveOnly)
  PrimaryCoil_2 [copper] = PrimaryCoil_1.split(plane=ZX, keep=Both)
  PrimaryCoil_1.separate_bodies()
  PrimaryCoil_1_Section1 = PrimaryCoil_1.section(plane=YZ)
  PrimaryCoil_1_Section1_1 [copper] = PrimaryCoil_1_Section1.separate_bodies()
  PrimaryCoil_1_Section1.delete()
  PrimaryCoil_2_Section1 = PrimaryCoil_2.section(plane=YZ)
  PrimaryCoil_2_Section1_1 [copper] = PrimaryCoil_2_Section1.separate_bodies()
  PrimaryCoil_2_Section1.delete()
  Aluminum [aluminum] = box(corner=(-500mm, -150mm, -(FerriteCoilGap + 8mm + AluminumFerriteGap + AluminumThickness)), size=(1000mm, 300mm, AluminumThickness))
  PrimaryFerrite1 [ferrite] = box(corner=(FirstFerritePosition, -54mm, -(8mm + FerriteCoilGap)), size=(14.8mm, 108.4mm, 8mm))
  PrimaryFerrite1_1..PrimaryFerrite1_9 [ferrite] = PrimaryFerrite1.duplicate_along_line(step=(PrimaryFerriteSpacing, 0mm, 0mm), total=10)
boundaries and excitations:
  Insulating1: Insulating Objects=[PrimaryCoil_1, PrimaryCoil_2]
  L_st: Current Objects=SeconadaryCoil_Section1 Phase=0deg Current=N2*I2 IsSolid=false Point_out_of_terminal=false
  L_pt1: Current Objects=PrimaryCoil_1_Section1_1 Phase=0deg Current=N*I IsSolid=false Point_out_of_terminal=false
  L_pt2: Current Objects=PrimaryCoil_2_Section1_1 Phase=0deg Current=N*I IsSolid=false Point_out_of_terminal=false
parameters:
  Matrix1: Matrix Reduce_Matrices{ReduceMatrix1{JoinSeries1{Type="Join in Series" Matrix=2 Sources=L_pt1, L_pt2}}}; L_st, L_pt1, L_pt2:
mesh:
  initial mesh: GlobalCurvilinear{Apply}
setups:
  Setup1: EddyCurrent MaximumPasses=30 MinimumPasses=2 MinimumConvergedPasses=1 PercentRefinement=30 PercentError=1 NonLinearResidual=0.0001 Frequency=60Hz
optimetrics:
  CuttoutOffset: Parametric Sim._Setups=[Setup1]
    sweep PrimaryCuttoutOffset: LIN 80mm 130mm 10mm
    calculate Lst on Setup1 : LastAdaptive at Freq 60Hz
    calculate Lpt on Setup1 : LastAdaptive at Freq 60Hz
    calculate M on Setup1 : LastAdaptive at Freq 60Hz
    calculate K on Setup1 : LastAdaptive at Freq 60Hz
  CuttoutWidth: Parametric Sim._Setups=[Setup1]
    sweep PrimaryCuttoutWidth: LIN 30mm 70mm 10mm
    calculate Lst on Setup1 : LastAdaptive at Freq 60Hz
    calculate Lpt on Setup1 : LastAdaptive at Freq 60Hz
    calculate K on Setup1 : LastAdaptive at Freq 60Hz
    calculate M on Setup1 : LastAdaptive at Freq 60Hz
output variables:
  Lst = L(L_st,L_st)
  Lpt = L(JoinSeries1,JoinSeries1)
  M = L(JoinSeries1,L_st)
  K = M/(sqrt(Lst*Lpt))
reports:
  Output Variables Plot 1: Lpt, Lpt vs PrimaryCuttoutOffset on Setup1 : LastAdaptive [Freq=all PrimaryCuttoutWidth=all]
  Output Variables Plot 2: Lpt vs PrimaryCuttoutWidth on Setup1 : LastAdaptive [Freq=all PrimaryCuttoutOffset=all]
